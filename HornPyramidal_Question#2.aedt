# Ansys Electronics Desktop project, version 2021.2
materials:
  vacuum: permittivity=1
  pec: conductivity=1e+30

design HornPyramidal_ATK (HFSS, DrivenModal, model units in)
options: Allow_Material_Override Save_Adaptive_support_files open_region{WithHybridAndArrays BoundaryType=0 OpFreq=95GHz}
variables:
  # --Antenna Dimensions
  Horn_a = 0.236in
  Horn_b = 0.195in
  Horn_length = 0.84in
  # --Standard Waveguide
  WG_a = 0.1in
  WG_b = 0.05in
  WG_Wall_Thickness = 0.01in
  WG_length = 0.26in
geometry:
  NewObject_ZXTGH3 = box(corner=(-WG_a/2, -WG_b/2, -WG_length), size=(WG_a, WG_b, WG_length))
  NewObject_PYEFAM = box(corner=(-WG_a/2-WG_Wall_Thickness, -WG_b/2-WG_Wall_Thickness, -WG_length), size=(WG_a+2*WG_Wall_Thickness, WG_b+2*WG_Wall_Thickness, WG_length))
  NewObject_PYEFAM.subtract(NewObject_ZXTGH3)
  WG_inner [vacuum] = box(corner=(-WG_a/2, -WG_b/2, -WG_length), size=(WG_a, WG_b, WG_length))
  port1 = rectangle(corner=(-WG_a/2, -WG_b/2, -WG_length), x_size=WG_a, y_size=WG_b)
  NewObject_56RCGS = rectangle(corner=(-WG_a/2, -WG_b/2, 0in), x_size=WG_a, y_size=WG_b)
  NewObject_T3CEIH = rectangle(corner=(-WG_a/2-WG_Wall_Thickness, -WG_b/2-WG_WALL_Thickness, 0in), x_size=WG_a+2*WG_Wall_Thickness, y_size=WG_b+2*WG_Wall_Thickness)
  NewObject_X0YGLA = rectangle(corner=(-Horn_a/2, -Horn_b/2, Horn_Length), x_size=Horn_a, y_size=Horn_b)
  Horn [pec] = rectangle(corner=(-Horn_a/2-WG_Wall_Thickness, -Horn_b/2-WG_WALL_Thickness, Horn_Length), x_size=Horn_a+2*WG_Wall_Thickness, y_size=Horn_b+2*WG_Wall_Thickness)
  Horn.connect(NewObject_T3CEIH)
  NewObject_56RCGS.connect(NewObject_X0YGLA)
  Horn.subtract(NewObject_56RCGS)
  Horn.unite(NewObject_PYEFAM)
  NewObject_2GO17U = rectangle(corner=(-WG_a/2, -WG_b/2, 0in), x_size=WG_a, y_size=WG_b)
  NewObject_OL31JC = rectangle(corner=(-Horn_a/2, -Horn_b/2, Horn_Length), x_size=Horn_a, y_size=Horn_b)
  NewObject_2GO17U.connect(NewObject_OL31JC)
  WG_inner.unite(NewObject_2GO17U)
  RadiatingSurface [vacuum] = region(absolute_offset=0.041442188in on all sides)
  Box1 [vacuum] = box(corner=(-0.118in, -0.0975in, 0.84in), size=(0.236in, 0.195in, 0.062in))
  Polyline1 = polyline(xyz in in: (-0.128, -0.1075, 0.84) (-0.118, -0.0975, 0.902) (0.118, -0.0975, 0.902) (0.128, -0.1075, 0.84) (-0.128, -0.1075, 0.84), closed, covered)
  Polyline2 = polyline(xyz in in: (0.118, -0.0975, 0.902) (0.118, 0.0975, 0.902) (0.128, 0.1075, 0.84) (0.128, -0.1075, 0.84) (0.118, -0.0975, 0.902), closed, covered)
  Polyline3 = polyline(xyz in in: (0.118, 0.0975, 0.902) (0.128, 0.1075, 0.84) (-0.128, 0.1075, 0.84) (-0.118, 0.0975, 0.902) (0.118, 0.0975, 0.902), closed, covered)
  Polyline4 = polyline(xyz in in: (-0.118, 0.0975, 0.902) (-0.128, 0.1075, 0.84) (-0.128, -0.1075, 0.84) (-0.118, -0.0975, 0.902) (-0.118, 0.0975, 0.902), closed, covered)
  Box1.uncover_faces(FacesToUncover=Box1.face(+z))
  coordinate_system RelativeCS1 = origin=(0.33in, 0.69in, 0in) x=(1in, 0in, 0in) y=(0in, 1in, 0in)
  Box1.uncover_faces(FacesToUncover=Box1.face(-z))
  Cylinder1 [vacuum] = cylinder(axis=Z, base_centre=(-0.33in, -0.69in, (-0.27-0.128+0.01) in), radius=0.375in, height=0.128in) in RelativeCS1
  Box2 = box(corner=(-0.28in, -0.715in, -0.26in), size=(-0.1in, 0.05in, -0.128in)) in RelativeCS1
  Cylinder1.subtract(Box2)
  Cylinder2 = cylinder(axis=Z, base_centre=(-0.33in, -0.95437943in, 0.0038297872in), radius=0.04in, height=-3.5206383in) in RelativeCS1
  Cylinder3 = cylinder(axis=Z, base_centre=(-0.33in, -0.95437943in, 0.0038297872in), radius=0.04in, height=-3.5206383in) in RelativeCS1
  Cylinder4 = cylinder(axis=Z, base_centre=(-0.34in, -0.42in, 0in), radius=0.04in, height=-4.1in) in RelativeCS1
  Cylinder5 = cylinder(axis=Z, base_centre=(-0.06in, -0.68in, 0in), radius=0.04in, height=-3.7in) in RelativeCS1
  Cylinder6 = cylinder(axis=Z, base_centre=(-0.56in, -0.69in, 0in), radius=0.041231056in, height=-6.5in) in RelativeCS1
  Cylinder1.subtract(Cylinder3..Cylinder6)
  Cylinder1.subtract(Cylinder2)
  Cylinder7 = cylinder(axis=Z, base_centre=(-0.33in, -0.69in, -0.26in), radius=0.15306943in, height=-0.192in) in RelativeCS1
  Cylinder1.unite(Cylinder7)
  Box3 = box(corner=(-0.28in, -0.715in, -0.26in), size=(-0.1in, 0.05in, -2.2in)) in RelativeCS1
  Cylinder1.subtract(Box3)
  pecCap1 [pec] = sweep_along_normal(port1.face(at (0, 0, -0.26)), length=-0.01in)
boundaries and excitations:
  AutoOpen1: Radiation Objects=RadiatingSurface
  1: Wave Port Faces=port1.face(at (0, 0, -0.26)) NumModes=1 Modes{Mode1{IntLine{port1.edge(y opposite corner) at 0.55 along -> port1.edge(y at corner) at 0.45 along} CharImp=Zpi}}
setups:
  ATK_Solution: HfssDriven Frequency=95GHz MaxDeltaS=0.02 MaximumPasses=15 MinimumPasses=1 MinimumConvergedPasses=1 PercentRefinement=30 BasisOrder=1 PortAccuracy=2 IESolverType=ACA
    sweep FF_Sweep: 47.5GHz to 142.5GHz, 3 points; Type=Discrete SaveFields
    sweep SParam_Sweep: 47.5GHz to 142.5GHz, 100 points; Type=Interpolating InterpTolerance=0.5 InterpMaxSolns=250 InterpUsePortImped=false PassivityErrorTolerance=0.0001
source amplitudes:
  1:1: 1W 0deg
radiation setups:
  3D: Infinite Sphere Theta=0deg..180deg step 2deg Phi=-180deg..180deg step 2deg
  Elevation: Infinite Sphere Theta=-180deg..180deg step 1deg Phi=0deg..90deg step 90deg
  Azimuth: Infinite Sphere Theta=90deg..90deg step 0deg Phi=-180deg..180deg step 1deg
  ATK_2D: Infinite Sphere Theta=-180deg..180deg step 1deg Phi=0deg..90deg step 90deg
  ATK_3D: Infinite Sphere Theta=-180deg..180deg step 2deg Phi=0deg..180deg step 5deg
reports:
  ff_3D_GainTotal: dB(GainTotal) vs Phi, Theta on ATK_Solution : LastAdaptive, ATK_3D [Freq=9.5e+10]
  ff_2D_GainTotal: dB(GainTotal) vs Theta on ATK_Solution : LastAdaptive, ATK_2D [Phi=all Freq=9.5e+10]
  ff_2D_GainTotal_Stacked: dB(GainTotal) vs Theta on ATK_Solution : FF_Sweep, ATK_2D [Phi=all Freq=all]
  Return Loss: dB(S11) vs Freq on ATK_Solution : SParam_Sweep
  Input Impedance: S11 on ATK_Solution : SParam_Sweep [Freq=all]
