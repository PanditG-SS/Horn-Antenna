# Ansys Electronics Desktop project, version 2021.2
materials:
  vacuum: permittivity=1
  pec: conductivity=1e+30

design HornPyramidal_ATK (HFSS, DrivenModal, model units in)
options: Allow_Material_Override Save_Adaptive_support_files open_region{WithHybridAndArrays BoundaryType=0 OpFreq=95GHz}
variables:
  # --Antenna Dimensions
  Horn_a = 1.09in
  Horn_b = 0.89in
  Horn_length = 2.54in
  # --Standard Waveguide
  WG_a = 0.1in
  WG_b = 0.05in
  WG_Wall_Thickness = 0.044in
  WG_length = 0.26in
geometry:
  NewObject_JL6F9G = box(corner=(-WG_a/2, -WG_b/2, -WG_length), size=(WG_a, WG_b, WG_length))
  NewObject_YHJ5NP = box(corner=(-WG_a/2-WG_Wall_Thickness, -WG_b/2-WG_Wall_Thickness, -WG_length), size=(WG_a+2*WG_Wall_Thickness, WG_b+2*WG_Wall_Thickness, WG_length))
  NewObject_YHJ5NP.subtract(NewObject_JL6F9G)
  WG_inner [vacuum] = box(corner=(-WG_a/2, -WG_b/2, -WG_length), size=(WG_a, WG_b, WG_length))
  port1 = rectangle(corner=(-WG_a/2, -WG_b/2, -WG_length), x_size=WG_a, y_size=WG_b)
  NewObject_JPAU9V = rectangle(corner=(-WG_a/2, -WG_b/2, 0in), x_size=WG_a, y_size=WG_b)
  NewObject_2YD603 = rectangle(corner=(-WG_a/2-WG_Wall_Thickness, -WG_b/2-WG_WALL_Thickness, 0in), x_size=WG_a+2*WG_Wall_Thickness, y_size=WG_b+2*WG_Wall_Thickness)
  NewObject_297S8W = rectangle(corner=(-Horn_a/2, -Horn_b/2, Horn_Length), x_size=Horn_a, y_size=Horn_b)
  Horn = rectangle(corner=(-Horn_a/2-WG_Wall_Thickness, -Horn_b/2-WG_WALL_Thickness, Horn_Length), x_size=Horn_a+2*WG_Wall_Thickness, y_size=Horn_b+2*WG_Wall_Thickness)
  Horn.connect(NewObject_2YD603)
  NewObject_JPAU9V.connect(NewObject_297S8W)
  Horn.subtract(NewObject_JPAU9V)
  Horn.unite(NewObject_YHJ5NP)
  NewObject_RNF2X0 = rectangle(corner=(-WG_a/2, -WG_b/2, 0in), x_size=WG_a, y_size=WG_b)
  NewObject_81TDW4 = rectangle(corner=(-Horn_a/2, -Horn_b/2, Horn_Length), x_size=Horn_a, y_size=Horn_b)
  NewObject_RNF2X0.connect(NewObject_81TDW4)
  WG_inner.unite(NewObject_RNF2X0)
  RadiatingSurface [vacuum] = region(absolute_offset=0.041442188in on all sides)
  Box1 [vacuum] = box(corner=(-0.545in, -0.445in, 2.54in), size=(1.09in, 0.89in, 0.062in))
  Polyline1 = polyline(xyz in in: (0.545, -0.445, 2.602) (0.589, -0.489, 2.54) (0.589, 0.489, 2.54) (0.545, 0.445, 2.602) (0.545, -0.445, 2.602), closed, covered)
  Polyline2 = polyline(xyz in in: (-0.545, 0.445, 2.602) (-0.589, 0.489, 2.54) (0.589, 0.489, 2.54) (0.545, 0.445, 2.602) (-0.545, 0.445, 2.602), closed, covered)
  Polyline3 = polyline(xyz in in: (-0.545, 0.445, 2.602) (-0.589, 0.489, 2.54) (-0.589, -0.489, 2.54) (-0.545, -0.445, 2.602) (-0.545, 0.445, 2.602), closed, covered)
  Polyline4 = polyline(xyz in in: (0.545, -0.445, 2.602) (0.589, -0.489, 2.54) (-0.589, -0.489, 2.54) (-0.545, -0.445, 2.602) (0.545, -0.445, 2.602), closed, covered)
  coordinate_system RelativeCS1 = origin=(2.55in, 2.85in, 0in) x=(1in, 0in, 0in) y=(0in, 1in, 0in)
  Box1.uncover_faces(FacesToUncover=Box1.face(+z))
  WG_inner.uncover_faces(FacesToUncover=NewObject_81TDW4.face)
  Box1.uncover_faces(FacesToUncover=Box1.face(-z))
  Cylinder1 [vacuum] = cylinder(axis=Z, base_centre=(-2.55in, -2.85in, -0.26in), radius=0.375in, height=-0.125in) in RelativeCS1
  Cylinder2 [vacuum] = cylinder(axis=Z, base_centre=(-2.55in, -2.85in, -0.385in), radius=0.2in, height=(-0.0375/2) in) in RelativeCS1
  Box2 = box(corner=(-2.5in, -2.875in, -0.26in), size=(-0.1in, 0.05in, -1.84in)) in RelativeCS1
  Box2_1 = Box2.copy()
  Cylinder1.subtract(Box2_1)
  Cylinder2.subtract(Box2)
  Cylinder1.unite(Horn)
  Cylinder3 = cylinder(axis=Z, base_centre=(-2.85in, -2.84in, 0in), radius=0.05in, height=-3.39625in) in RelativeCS1
  Cylinder4 = cylinder(axis=Z, base_centre=(-2.56in, -3.15in, 0in), radius=0.05in, height=-2.75in) in RelativeCS1
  Cylinder5 = cylinder(axis=Z, base_centre=(-2.25in, -2.85in, 0in), radius=0.05in, height=-3.1in) in RelativeCS1
  Cylinder6 = cylinder(axis=Z, base_centre=(-2.55in, -2.55in, 0in), radius=0.05in, height=-3.45in) in RelativeCS1
  Cylinder1.subtract(Cylinder3..Cylinder6)
  pecCap1 [pec] = sweep_along_normal(port1.face(at (0, 0, -0.26)), length=-0.01in)
boundaries and excitations:
  AutoOpen1: Radiation Objects=RadiatingSurface
  1: Wave Port Faces=port1.face(at (0, 0, -0.26)) NumModes=1 Modes{Mode1{IntLine{middle of port1.edge(y opposite corner) -> middle of port1.edge(y at corner)} CharImp=Zpi}}
mesh:
  initial mesh: GlobalSurfApproximation{CurvedSurfaceApproxChoice=UseSlider SliderMeshSettings=3}
setups:
  ATK_Solution: HfssDriven Frequency=95GHz MaxDeltaS=0.02 MaximumPasses=1 MinimumPasses=1 MinimumConvergedPasses=1 PercentRefinement=30 BasisOrder=1 PortAccuracy=2 IESolverType=ACA
    sweep FF_Sweep: 47.5GHz to 142.5GHz, 3 points; Type=Discrete SaveFields
    sweep SParam_Sweep: 47.5GHz to 142.5GHz, 100 points; Type=Interpolating InterpTolerance=0.5 InterpMaxSolns=250 InterpUsePortImped=false PassivityErrorTolerance=0.0001
source amplitudes:
  1:1: 1W 0deg
radiation setups:
  3D: Infinite Sphere Theta=0deg..180deg step 2deg Phi=-180deg..180deg step 2deg
  Elevation: Infinite Sphere Theta=-180deg..180deg step 1deg Phi=0deg..90deg step 90deg
  Azimuth: Infinite Sphere Theta=90deg..90deg step 0deg Phi=-180deg..180deg step 1deg
  ATK_2D: Infinite Sphere Theta=-180deg..180deg step 1deg Phi=0deg..90deg step 90deg
  ATK_3D: Infinite Sphere Theta=-180deg..180deg step 2deg Phi=0deg..180deg step 5deg
reports:
  ff_3D_GainTotal: dB(GainTotal) vs Phi, Theta on ATK_Solution : LastAdaptive, ATK_3D [Freq=9.5e+10]
  ff_2D_GainTotal: dB(GainTotal) vs Theta on ATK_Solution : LastAdaptive, ATK_2D [Phi=all Freq=9.5e+10]
  ff_2D_GainTotal_Stacked: dB(GainTotal) vs Theta on ATK_Solution : FF_Sweep, ATK_2D [Phi=all Freq=all]
  Return Loss: dB(S11) vs Freq on ATK_Solution : SParam_Sweep
  Input Impedance: S11 on ATK_Solution : SParam_Sweep [Freq=all]
