# Ansys Electronics Desktop project, version 2021.2
materials:
  vacuum: permittivity=1
  pec: conductivity=1e+30

design HornPyramidal_ATK (HFSS, DrivenModal, model units in)
options: Allow_Material_Override Save_Adaptive_support_files open_region{WithHybridAndArrays BoundaryType=0 OpFreq=95GHz}
variables:
  # --Antenna Dimensions
  Horn_a = 0.526in
  Horn_b = 0.623in
  Horn_length = 1.18in
  # --Standard Waveguide
  WG_a = 0.1in
  WG_b = 0.05in
  WG_Wall_Thickness = 0.01in
  WG_length = 0.26in
geometry:
  NewObject_GXWSUO = box(corner=(-WG_a/2, -WG_b/2, -WG_length), size=(WG_a, WG_b, WG_length))
  NewObject_YDHTFO = box(corner=(-WG_a/2-WG_Wall_Thickness, -WG_b/2-WG_Wall_Thickness, -WG_length), size=(WG_a+2*WG_Wall_Thickness, WG_b+2*WG_Wall_Thickness, WG_length))
  NewObject_YDHTFO.subtract(NewObject_GXWSUO)
  WG_inner [vacuum] = box(corner=(-WG_a/2, -WG_b/2, -WG_length), size=(WG_a, WG_b, WG_length))
  port1 = rectangle(corner=(-WG_a/2, -WG_b/2, -WG_length), x_size=WG_a, y_size=WG_b)
  NewObject_LQEY64 = rectangle(corner=(-WG_a/2, -WG_b/2, 0in), x_size=WG_a, y_size=WG_b)
  NewObject_E2PTA7 = rectangle(corner=(-WG_a/2-WG_Wall_Thickness, -WG_b/2-WG_WALL_Thickness, 0in), x_size=WG_a+2*WG_Wall_Thickness, y_size=WG_b+2*WG_Wall_Thickness)
  NewObject_XH7U41 = rectangle(corner=(-Horn_a/2, -Horn_b/2, Horn_Length), x_size=Horn_a, y_size=Horn_b)
  Horn [pec] = rectangle(corner=(-Horn_a/2-WG_Wall_Thickness, -Horn_b/2-WG_WALL_Thickness, Horn_Length), x_size=Horn_a+2*WG_Wall_Thickness, y_size=Horn_b+2*WG_Wall_Thickness)
  Horn.connect(NewObject_E2PTA7)
  NewObject_LQEY64.connect(NewObject_XH7U41)
  Horn.subtract(NewObject_LQEY64)
  Horn.unite(NewObject_YDHTFO)
  NewObject_28WCY6 = rectangle(corner=(-WG_a/2, -WG_b/2, 0in), x_size=WG_a, y_size=WG_b)
  NewObject_M07DIV = rectangle(corner=(-Horn_a/2, -Horn_b/2, Horn_Length), x_size=Horn_a, y_size=Horn_b)
  NewObject_28WCY6.connect(NewObject_M07DIV)
  WG_inner.unite(NewObject_28WCY6)
  RadiatingSurface [vacuum] = region(absolute_offset=0.041442188in on all sides)
  Box1 [vacuum, non-model] = box(corner=(-0.263in, -0.3115in, 1.18in), size=(0.526in, 0.623in, 0.062in))
  Polyline1 [non-model] = polyline(xyz in in: (-0.273, -0.3215, 1.18) (-0.263, -0.3115, 1.242) (-0.263, 0.3115, 1.242) (-0.273, 0.3215, 1.18) (-0.273, -0.3215, 1.18), closed, covered)
  Polyline2 = polyline(xyz in in: (-0.273, 0.3215, 1.18) (-0.263, 0.3115, 1.242) (0.263, 0.3115, 1.242) (0.273, 0.3215, 1.18) (-0.273, 0.3215, 1.18), closed, covered)
  Polyline3 = polyline(xyz in in: (0.273, 0.3215, 1.18) (0.263, 0.3115, 1.242) (0.263, -0.3115, 1.242) (0.273, -0.3215, 1.18) (0.273, 0.3215, 1.18), closed, covered)
  Polyline4 = polyline(xyz in in: (-0.263, -0.3115, 1.242) (-0.273, -0.3215, 1.18) (0.273, -0.3215, 1.18) (0.263, -0.3115, 1.242) (-0.263, -0.3115, 1.242), closed, covered)
  Polyline5 [non-model] = polyline(xyz in in: (-0.263, 0.3115, 1.242) (-0.273, 0.3215, 1.18) (-0.273, -0.3215, 1.18) (-0.263, -0.3115, 1.242) (-0.263, 0.3115, 1.242), closed, covered)
  Box1.uncover_faces(FacesToUncover=Box1.face(+z))
  Box1.uncover_faces(FacesToUncover=Box1.face(-z))
  Polyline5.unite(Polyline2, Polyline4, Polyline3)
  Cylinder1 = cylinder(axis=Z, base_centre=(0in, 0in, -0.26in), radius=0.375in, height=(0.032-0.16) in)
  Box2 = box(corner=(0.05in, -0.025in, -0.26in), size=(-0.1in, 0.05in, -1.84in))
  Cylinder1.subtract(Box2)
  Horn.unite(Cylinder1)
  Cylinder2 = cylinder(axis=Z, base_centre=(0in, 0.22in, 0in), radius=0.05in, height=-0.8in)
  Cylinder3 = cylinder(axis=Z, base_centre=(0in, -0.22in, 0in), radius=0.05in, height=-1in)
  Cylinder4 = cylinder(axis=Z, base_centre=(0.22in, 0in, 0in), radius=0.045029453in, height=-1in)
  Cylinder5 = cylinder(axis=Z, base_centre=(-0.22in, 0in, 0in), radius=0.05in, height=-1in)
  Horn.subtract(Cylinder2..Cylinder5)
  pecCap1 [pec] = sweep_along_normal(port1.face(at (0, 0, -0.26)), length=-0.01in)
boundaries and excitations:
  AutoOpen1: Radiation Objects=RadiatingSurface
  1: Wave Port Faces=port1.face(at (0, 0, -0.26)) NumModes=1 Modes{Mode1{IntLine{middle of port1.edge(y opposite corner) -> middle of port1.edge(y at corner)} CharImp=Zpi}}
setups:
  ATK_Solution: HfssDriven Frequency=95GHz MaxDeltaS=0.02 MaximumPasses=15 MinimumPasses=1 MinimumConvergedPasses=1 PercentRefinement=30 BasisOrder=1 PortAccuracy=2 IESolverType=ACA
    sweep FF_Sweep: 47.5GHz to 142.5GHz, 3 points; Type=Discrete SaveFields
    sweep SParam_Sweep: 47.5GHz to 142.5GHz, 100 points; Type=Interpolating InterpTolerance=0.5 InterpMaxSolns=250 InterpUsePortImped=false PassivityErrorTolerance=0.0001
source amplitudes:
  1:1: 1W 0deg
radiation setups:
  3D: Infinite Sphere Theta=0deg..180deg step 2deg Phi=-180deg..180deg step 2deg
  Elevation: Infinite Sphere Theta=-180deg..180deg step 1deg Phi=0deg..90deg step 90deg
  Azimuth: Infinite Sphere Theta=90deg..90deg step 0deg Phi=-180deg..180deg step 1deg
  ATK_2D: Infinite Sphere Theta=-180deg..180deg step 1deg Phi=0deg..90deg step 90deg
  ATK_3D: Infinite Sphere Theta=-180deg..180deg step 2deg Phi=0deg..180deg step 5deg
reports:
  ff_3D_GainTotal: dB(GainTotal) vs Phi, Theta on ATK_Solution : LastAdaptive, ATK_3D [Freq=9.5e+10]
  ff_2D_GainTotal: dB(GainTotal) vs Theta on ATK_Solution : LastAdaptive, ATK_2D [Phi=all Freq=9.5e+10]
  ff_2D_GainTotal_Stacked: dB(GainTotal) vs Theta on ATK_Solution : FF_Sweep, ATK_2D [Phi=all Freq=all]
  Return Loss: dB(S11) vs Freq on ATK_Solution : SParam_Sweep
  Input Impedance: S11 on ATK_Solution : SParam_Sweep [Freq=all]
  S Parameter Chart 1: S(1,1) on ATK_Solution : SParam_Sweep [Freq=all]
