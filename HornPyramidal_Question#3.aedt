# Ansys Electronics Desktop project, version 2021.2
materials:
  vacuum: permittivity=1
  pec: conductivity=1e+30

design HornPyramidal_ATK (HFSS, DrivenModal, model units in)
options: Allow_Material_Override Save_Adaptive_support_files open_region{WithHybridAndArrays BoundaryType=0 OpFreq=95GHz}
variables:
  # --Antenna Dimensions
  Horn_a = 0.26in
  Horn_b = 0.21in
  Horn_length = 0.664in
  # --Standard Waveguide
  WG_a = 0.1in
  WG_b = 0.05in
  WG_Wall_Thickness = 0.045in
  WG_length = 0.26in
geometry:
  NewObject_NQG9YC = box(corner=(-WG_a/2, -WG_b/2, -WG_length), size=(WG_a, WG_b, WG_length))
  NewObject_CU83VH = box(corner=(-WG_a/2-WG_Wall_Thickness, -WG_b/2-WG_Wall_Thickness, -WG_length), size=(WG_a+2*WG_Wall_Thickness, WG_b+2*WG_Wall_Thickness, WG_length))
  NewObject_CU83VH.subtract(NewObject_NQG9YC)
  WG_inner [vacuum] = box(corner=(-WG_a/2, -WG_b/2, -WG_length), size=(WG_a, WG_b, WG_length))
  port1 = rectangle(corner=(-WG_a/2, -WG_b/2, -WG_length), x_size=WG_a, y_size=WG_b)
  NewObject_AG63P5 = rectangle(corner=(-WG_a/2, -WG_b/2, 0in), x_size=WG_a, y_size=WG_b)
  NewObject_QAF86D = rectangle(corner=(-WG_a/2-WG_Wall_Thickness, -WG_b/2-WG_WALL_Thickness, 0in), x_size=WG_a+2*WG_Wall_Thickness, y_size=WG_b+2*WG_Wall_Thickness)
  NewObject_U5DTAX = rectangle(corner=(-Horn_a/2, -Horn_b/2, Horn_Length), x_size=Horn_a, y_size=Horn_b)
  Horn = rectangle(corner=(-Horn_a/2-WG_Wall_Thickness, -Horn_b/2-WG_WALL_Thickness, Horn_Length), x_size=Horn_a+2*WG_Wall_Thickness, y_size=Horn_b+2*WG_Wall_Thickness)
  Horn.connect(NewObject_QAF86D)
  NewObject_AG63P5.connect(NewObject_U5DTAX)
  Horn.subtract(NewObject_AG63P5)
  Horn.unite(NewObject_CU83VH)
  NewObject_1OC6YI = rectangle(corner=(-WG_a/2, -WG_b/2, 0in), x_size=WG_a, y_size=WG_b)
  NewObject_N38E2P = rectangle(corner=(-Horn_a/2, -Horn_b/2, Horn_Length), x_size=Horn_a, y_size=Horn_b)
  NewObject_1OC6YI.connect(NewObject_N38E2P)
  WG_inner.unite(NewObject_1OC6YI)
  RadiatingSurface [vacuum] = region(absolute_offset=0.041442188in on all sides)
  Box1 [vacuum] = box(corner=(-0.13in, -0.105in, 0.664in), size=(0.26in, 0.21in, 0.062in))
  Polyline1 = polyline(xyz in in: (-0.13, 0.105, 0.726) (-0.175, 0.15, 0.664) (-0.175, -0.15, 0.664) (-0.13, -0.105, 0.726) (-0.13, 0.105, 0.726), closed, covered)
  Polyline2 = polyline(xyz in in: (-0.13, -0.105, 0.726) (-0.175, -0.15, 0.664) (0.175, -0.15, 0.664) (0.13, -0.105, 0.726) (-0.13, -0.105, 0.726), closed, covered)
  Polyline3 = polyline(xyz in in: (0.13, 0.105, 0.726) (0.175, 0.15, 0.664) (0.175, -0.15, 0.664) (0.13, -0.105, 0.726) (0.13, 0.105, 0.726), closed, covered)
  Polyline4 = polyline(xyz in in: (-0.175, 0.15, 0.664) (-0.13, 0.105, 0.726) (0.13, 0.105, 0.726) (0.175, 0.15, 0.664) (-0.175, 0.15, 0.664), closed, covered)
  Box1.uncover_faces(FacesToUncover=Box1.face(+z))
  WG_inner.uncover_faces(FacesToUncover=NewObject_N38E2P.face)
  Box1.uncover_faces(FacesToUncover=Box1.face(-z))
  Cylinder1 = cylinder(axis=Z, base_centre=(0in, 0in, -0.26in), radius=0.375in, height=(0.032-0.160) in)
  Cylinder2 [vacuum] = cylinder(axis=Z, base_centre=(0in, 0in, (-0.26+0.032-0.160) in), radius=(0.375/2) in, height=-0.02in)
  Box2 = box(corner=(0.05in, -0.025in, -0.26in), size=(-0.1in, 0.05in, -0.54in))
  Box2_1 = Box2.copy()
  Cylinder1.subtract(Box2_1)
  Cylinder2.subtract(Box2)
  Cylinder1.unite(Horn)
  Cylinder3 = cylinder(axis=Z, base_centre=(0in, 0.28in, 0in), radius=0.04in, height=-2.28in)
  Cylinder4 = cylinder(axis=Z, base_centre=(0in, -0.28in, 0in), radius=0.04in, height=-2.48in)
  Cylinder5 = cylinder(axis=Z, base_centre=(0.28in, 0in, 0in), radius=0.04in, height=-1.54in)
  Cylinder6 = cylinder(axis=Z, base_centre=(-0.28in, 0in, 0in), radius=0.04in, height=-1.4in)
  Cylinder7 [vacuum] = cylinder(axis=Z, base_centre=(-0.2in, 0.2in, (-0.26+0.032-0.16) in), radius=0.02in, height=-0.2in)
  Cylinder8 = cylinder(axis=Z, base_centre=(0.2in, -0.2in, (-0.26+0.032-0.16) in), radius=0.02in, height=-0.2in)
  Cylinder9 = cylinder(axis=Z, base_centre=(-0.2in, -0.2in, (-0.26+0.032-0.16) in), radius=0.02in, height=0.168in)
  Cylinder10 = cylinder(axis=Z, base_centre=(0.2in, 0.2in, (-0.26+0.032-0.16) in), radius=0.02in, height=0.168in)
  Cylinder1.subtract(Cylinder10, Cylinder3..Cylinder6, Cylinder9)
  Cylinder7.unite(Cylinder1, Cylinder8)
  pecCap1 [pec] = sweep_along_normal(port1.face(at (0, 0, -0.26)), length=-0.01in)
boundaries and excitations:
  AutoOpen1: Radiation Objects=RadiatingSurface
  1: Wave Port Faces=port1.face(at (0, 0, -0.26)) NumModes=1 Modes{Mode1{IntLine{middle of port1.edge(y at corner) -> middle of port1.edge(y opposite corner)} CharImp=Zpi}}
setups:
  ATK_Solution: HfssDriven Frequency=95GHz MaxDeltaS=0.02 MaximumPasses=2 MinimumPasses=1 MinimumConvergedPasses=1 PercentRefinement=30 BasisOrder=1 PortAccuracy=2 IESolverType=ACA
    sweep FF_Sweep: 47.5GHz to 142.5GHz, 3 points; Type=Discrete SaveFields
    sweep SParam_Sweep: 47.5GHz to 142.5GHz, 100 points; Type=Interpolating InterpTolerance=0.5 InterpMaxSolns=250 InterpUsePortImped=false PassivityErrorTolerance=0.0001
source amplitudes:
  1:1: 1W 0deg
radiation setups:
  3D: Infinite Sphere Theta=0deg..180deg step 2deg Phi=-180deg..180deg step 2deg
  Elevation: Infinite Sphere Theta=-180deg..180deg step 1deg Phi=0deg..90deg step 90deg
  Azimuth: Infinite Sphere Theta=90deg..90deg step 0deg Phi=-180deg..180deg step 1deg
  ATK_2D: Infinite Sphere Theta=-180deg..180deg step 1deg Phi=0deg..90deg step 90deg
  ATK_3D: Infinite Sphere Theta=-180deg..180deg step 2deg Phi=0deg..180deg step 5deg
reports:
  ff_3D_GainTotal: dB(GainTotal) vs Phi, Theta on ATK_Solution : LastAdaptive, ATK_3D [Freq=9.5e+10]
  ff_2D_GainTotal: dB(GainTotal) vs Theta on ATK_Solution : LastAdaptive, ATK_2D [Phi=all Freq=9.5e+10]
  ff_2D_GainTotal_Stacked: dB(GainTotal) vs Theta on ATK_Solution : FF_Sweep, ATK_2D [Phi=all Freq=all]
  Return Loss: dB(S11) vs Freq on ATK_Solution : SParam_Sweep
  Input Impedance: S11 on ATK_Solution : SParam_Sweep [Freq=all]
